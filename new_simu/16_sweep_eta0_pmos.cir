* 16 - PMOS SWEEP : DIBL coeff eta0 (p_eta0_p) with nested Vds for true DIBL
.include ptm22lp_param.lib
.param VDD = 0.95
.param WP  = 2u
.param LP  = 22n
.param ICRIT = 100n*WP/LP
M1  d  g  0  0  pmos  L={LP}  W={WP}
Vg  g  0  0
Vd  d  0  {VDS}
.step param p_eta0_p 0.000 0.030 0.003
.step param VDS list -0.05 -0.95
.dc Vg 0 {-VDD} -0.005
.meas dc VT   FIND V(g)   WHEN Id(M1)={-ICRIT}
.meas dc IOFF FIND Id(M1) AT=0
.meas dc ION  FIND Id(M1) AT={-VDD}
.end
