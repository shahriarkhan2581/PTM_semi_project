* ======================================================================
* 07 - PARAMETER SWEEP : Subthreshold factor  nfactor
* Sweeps p_nfac_n and extracts Vt, SS, Ion, Ioff at Vds = Vdd (saturation).
* Expectation: SS scales 1:1 with nfactor (SS = n*kT/q*ln10);
*   Ioff has the LARGEST sensitivity of all params (runs across decades);
*   Ion / delay / Vt essentially unchanged.
* ======================================================================
.include ptm22lp_param.lib

.param VDD  = 0.95
.param WN   = 1u
.param LN   = 22n
.param ICRIT = 100n*WN/LN

M1  d  g  0  0  nmos  L={LN}  W={WN}
Vg  g  0  0
Vd  d  0  {VDD}

* ---- SWEEP nfactor (nominal 1.6) ----
.step param p_nfac_n 1.2 2.4 0.1
.dc Vg 0 {VDD} 0.005

.meas dc VT     FIND V(g)   WHEN Id(M1)={ICRIT}
.meas dc V_1nA  FIND V(g)   WHEN Id(M1)=1n
.meas dc V_10nA FIND V(g)   WHEN Id(M1)=10n
.meas dc SS     PARAM (V_10nA-V_1nA)*1000
.meas dc IOFF   FIND Id(M1) AT=0
.meas dc ION    FIND Id(M1) AT={VDD}
.meas dc ION_IOFF PARAM ION/IOFF

.end
