* ======================================================================
* 05 - PARAMETER SWEEP : Electrical oxide thickness  toxe
* Sweeps p_toxe_n and extracts Vt, SS, Ion, Ioff at Vds = Vdd (saturation).
* Expectation: thinner toxe -> larger Cox -> Ion AND Ioff both rise;
*   delay ~ flat.  NOTE: with igcmod/igbmod ON, thinning toxe below ~1.1nm
*   also raises gate tunnelling leakage (visible in Ig).
* ======================================================================
.include ptm22lp_param.lib

.param VDD  = 0.95
.param WN   = 1u
.param LN   = 22n
.param ICRIT = 100n*WN/LN

M1  d  g  0  0  nmos  L={LN}  W={WN}
Vg  g  0  0
Vd  d  0  {VDD}

* ---- SWEEP OXIDE THICKNESS (nominal 1.4nm) ----
.step param TOX 1.0e-9 2.0e-9 0.1e-9
.dc Vg 0 {VDD} 0.005

.meas dc VT     FIND V(g)   WHEN Id(M1)={ICRIT}
.meas dc V_1nA  FIND V(g)   WHEN Id(M1)=1n
.meas dc V_10nA FIND V(g)   WHEN Id(M1)=10n
.meas dc SS     PARAM (V_10nA-V_1nA)*1000
.meas dc IOFF   FIND Id(M1) AT=0
.meas dc ION    FIND Id(M1) AT={VDD}
.meas dc ION_IOFF PARAM ION/IOFF

.end
