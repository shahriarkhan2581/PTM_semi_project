* ======================================================================
* 18 - GATE TUNNELING : Ig vs |Vgs|  (NMOS + PMOS together)
* Two independent devices biased in parallel from the same gate sweep.
* NMOS: source/bulk at 0, gate/drain positive.
* PMOS: source/bulk at Vdd, gate/drain swept below Vdd (|Vgs| grows).
* Ig(MP) is negative -> compared as magnitude in .meas.
* ======================================================================
.include ptm22lp_param.lib
.param VDD = 0.95
.param WN  = 1u
.param WP  = 2u
.param LL  = 22n

* ---- NMOS branch ----
MN  dn  g  0   0   nmos  L={LL}  W={WN}
VdN dn  0  {VDD}

* ---- PMOS branch (source/bulk tied to Vdd) ----
Vsup s  0  {VDD}
MP  dp  g  s   s   pmos  L={LL}  W={WP}
VdP dp  0  0

* ---- shared gate sweep: 0 -> Vdd (drives NMOS on; PMOS |Vgs| grows) ----
Vg  g  0  0
.dc Vg 0 {VDD} 0.005

* ---- NMOS gate leakage (Vgs = Vdd) ----
.meas dc IG_N   FIND Ig(MN) AT={VDD}
.meas dc ID_N   FIND Id(MN) AT={VDD}
.meas dc IGID_N PARAM IG_N/ID_N

* ---- PMOS gate leakage (|Vgs| = Vdd, i.e. gate at 0) ----
.meas dc IG_P   FIND Ig(MP) AT=0
.meas dc ID_P   FIND Id(MP) AT=0
.meas dc IGID_P PARAM IG_P/ID_P

* ---- direct comparison ----
.meas dc IG_RATIO PARAM IG_N/IG_P
.end
