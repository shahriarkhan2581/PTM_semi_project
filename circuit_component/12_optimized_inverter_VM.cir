* ======================================================================
* 12 - OPTIMIZED CMOS INVERTER : VTC, switching threshold VM, gain, leakage
* Same optimized parameter set as 11_optimized_inverter.cir.
* ======================================================================
.include ptm22lp_optimized.lib

.param VDD = 0.95
.param WN  = 1u
.param WP  = 2u
.param LN  = 22n

VDDs vdd 0 {VDD}
MP1  out in vdd vdd pmos L={LN} W={WP}
MN1  out in 0   0   nmos L={LN} W={WN}
Vin  in 0 0

.dc Vin 0 {VDD} 0.002

* switching threshold: Vin where Vout = Vin
.meas dc VM FIND V(in) WHEN V(out)=V(in)
* small-signal gain at switching point: finite-difference slope of V(out) around VM
.meas dc Vout_lo FIND V(out) AT={VM-0.005}
.meas dc Vout_hi FIND V(out) AT={VM+0.005}
.meas dc GAIN PARAM (Vout_hi-Vout_lo)/0.01

* ---- static leakage at both rail states ----
.meas dc I_LEAK_LOW  FIND I(VDDs) AT=0
.meas dc I_LEAK_HIGH FIND I(VDDs) AT={VDD}

.end
