* ======================================================================
* 06 - PARAMETER SWEEP : DIBL coefficient  eta0  (with true DIBL extraction)
* Nested step: outer = eta0, inner = Vds (0.05 & 0.95) so DIBL is measured.
*   DIBL[mV/V] = (VT@Vds0.05 - VT@Vds0.95)/(0.95-0.05)*1000
* Also extracts Ion, Ioff at the Vds=0.95 rows.
* ======================================================================
.include ptm22lp_param.lib

.param VDD  = 0.95
.param WN   = 1u
.param LN   = 22n
.param ICRIT = 100n*WN/LN

M1  d  g  0  0  nmos  L={LN}  W={WN}
Vg  g  0  0
Vd  d  0  {VDS}

* ---- SWEEP eta0 (nominal 0.0105); inner sweep = drain bias ----
.step param p_eta0_n 0.000 0.030 0.003
.step param VDS list 0.05 0.95
.dc Vg 0 {VDD} 0.005

.meas dc VT     FIND V(g)   WHEN Id(M1)={ICRIT}   ; VT_lin (Vds.05) & VT_sat (Vds.95)
.meas dc IOFF   FIND Id(M1) AT=0
.meas dc ION    FIND Id(M1) AT={VDD}

* In the SPICE error log the rows alternate Vds=0.05 / Vds=0.95 for each eta0.
* Pair them:  DIBL = (VT_lin - VT_sat)/0.9*1000  (mV/V)  ~ tracks eta0*1000.

.end
