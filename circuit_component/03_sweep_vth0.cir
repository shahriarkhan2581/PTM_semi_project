* ======================================================================
* 03 - PARAMETER SWEEP : Threshold voltage  vth0
* Sweeps p_vth0_n and extracts Vt, SS, Ion, Ioff at Vds = Vdd (saturation).
* Plot: run, then in the log window read the .meas table (one row per step).
*   Plot Id-Vg families:  right-click -> View -> SPICE Error Log -> or
*   simply plot Id(M1) after Ctrl-click for stepped traces.
* ======================================================================
.include ptm22lp_param.lib

.param VDD  = 0.95
.param WN   = 1u
.param LN   = 22n
.param ICRIT = 100n*WN/LN

M1  d  g  0  0  nmos  L={LN}  W={WN}
Vg  g  0  0
Vd  d  0  {VDD}                    ; saturation drain bias

* ---- SWEEP THE THRESHOLD (nominal 0.68858 V) ----
.step param p_vth0_n 0.55 0.82 0.03
.dc Vg 0 {VDD} 0.005

.meas dc VT     FIND V(g)   WHEN Id(M1)={ICRIT}
.meas dc V_1nA  FIND V(g)   WHEN Id(M1)=1n
.meas dc V_10nA FIND V(g)   WHEN Id(M1)=10n
.meas dc SS     PARAM (V_10nA-V_1nA)*1000
.meas dc IOFF   FIND Id(M1) AT=0
.meas dc ION    FIND Id(M1) AT={VDD}
.meas dc ION_IOFF PARAM ION/IOFF

.end
